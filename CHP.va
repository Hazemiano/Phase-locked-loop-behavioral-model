// VerilogA for , CHP, veriloga
// AMS PLL Project: Charge Pump (CHP)

`include "constants.vams"
`include "disciplines.vams"

// UP: Up signal
// DN: Dn signal
// IOUT: CHP current output
// Since the output is current, IOUT cannot be left unconnected (o.c.) in the testbench
module CHP(UP,DN,IOUT,AVDD,AVSS);
	input UP,DN;
	inout IOUT,AVDD,AVSS;
	electrical UP,DN,IOUT,AVDD,AVSS;

	// ichp: CHP current
	parameter real ichp = 10u from [0:inf);
	// Threshold voltage for digital signals
	parameter real thresh=0.6;
	// rise/fall/delay times of CHP output
	parameter real trise=10p, tfall=10p, td=0;

	// Internal variable for CHP output current
	real IOUT_i = 0;

	analog begin

		// Generate events at UP and DN transitions
		@ ((cross(V(UP)-thresh,0)) or (cross(V(DN)-thresh,0)));
		// *** add line here ***
		if ((V(UP) > thresh) && (V(DN) < thresh))
			IOUT_i = -ichp;
		// *** add line here ***
       else if ((V(UP) < thresh) && (V(DN) > thresh))
			IOUT_i = ichp;
		else
		        IOUT_i=0;

		I(IOUT) <+ transition(IOUT_i,td,trise,tfall);

	end
endmodule
